.SUBCKT C4AQOEW5800M3BJ 1 6
*Temp = 25?C, Bias = 0VDC, Center Frequency = 10000 Hz
*KEMET Model RLC Cerm
R1 3 4 0.0019368920475244522
R2 2 5 0.19368919730186462
R3 1 6 875000000
L1 1 2 2.591170478183358E-09
L2 2 3 4.9232239085483796E-08
C1 4 6 8.000032539712265E-05
C2 5 6 0
.ENDS
